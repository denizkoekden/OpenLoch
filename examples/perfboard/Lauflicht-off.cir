OpenLoch: ten real driver stages; generic models; off
VSUP VCC 0 5.25
.model NPN_GENERIC NPN(IS=1e-14 BF=200 VAF=100 IKF=.1)
.model LED_RED D(IS=1e-20 N=2 RS=4)
VDRIVE0 OUT0 0 0.05
RB0 OUT0 BASE0 20900.0
RL0 VCC LED0_A 1425.0
D0 LED0_A COL0 LED_RED
Q0 COL0 BASE0 0 NPN_GENERIC
VDRIVE1 OUT1 0 0.05
RB1 OUT1 BASE1 20900.0
RL1 VCC LED1_A 1425.0
D1 LED1_A COL1 LED_RED
Q1 COL1 BASE1 0 NPN_GENERIC
VDRIVE2 OUT2 0 0.05
RB2 OUT2 BASE2 20900.0
RL2 VCC LED2_A 1425.0
D2 LED2_A COL2 LED_RED
Q2 COL2 BASE2 0 NPN_GENERIC
VDRIVE3 OUT3 0 0.05
RB3 OUT3 BASE3 20900.0
RL3 VCC LED3_A 1425.0
D3 LED3_A COL3 LED_RED
Q3 COL3 BASE3 0 NPN_GENERIC
VDRIVE4 OUT4 0 0.05
RB4 OUT4 BASE4 20900.0
RL4 VCC LED4_A 1425.0
D4 LED4_A COL4 LED_RED
Q4 COL4 BASE4 0 NPN_GENERIC
VDRIVE5 OUT5 0 0.05
RB5 OUT5 BASE5 20900.0
RL5 VCC LED5_A 1425.0
D5 LED5_A COL5 LED_RED
Q5 COL5 BASE5 0 NPN_GENERIC
VDRIVE6 OUT6 0 0.05
RB6 OUT6 BASE6 20900.0
RL6 VCC LED6_A 1425.0
D6 LED6_A COL6 LED_RED
Q6 COL6 BASE6 0 NPN_GENERIC
VDRIVE7 OUT7 0 0.05
RB7 OUT7 BASE7 20900.0
RL7 VCC LED7_A 1425.0
D7 LED7_A COL7 LED_RED
Q7 COL7 BASE7 0 NPN_GENERIC
VDRIVE8 OUT8 0 0.05
RB8 OUT8 BASE8 20900.0
RL8 VCC LED8_A 1425.0
D8 LED8_A COL8 LED_RED
Q8 COL8 BASE8 0 NPN_GENERIC
VDRIVE9 OUT9 0 0.05
RB9 OUT9 BASE9 20900.0
RL9 VCC LED9_A 1425.0
D9 LED9_A COL9 LED_RED
Q9 COL9 BASE9 0 NPN_GENERIC
.control
set wr_singlescale
set wr_vecnames
op
wrdata Lauflicht-off.dat v(LED0_A) v(BASE0) v(COL0) v(LED1_A) v(BASE1) v(COL1) v(LED2_A) v(BASE2) v(COL2) v(LED3_A) v(BASE3) v(COL3) v(LED4_A) v(BASE4) v(COL4) v(LED5_A) v(BASE5) v(COL5) v(LED6_A) v(BASE6) v(COL6) v(LED7_A) v(BASE7) v(COL7) v(LED8_A) v(BASE8) v(COL8) v(LED9_A) v(BASE9) v(COL9)
.endc
.end
